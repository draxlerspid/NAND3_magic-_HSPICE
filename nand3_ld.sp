** HSPICE file for nand3_ld
**   - generated by ext2sp v9.0

** Include transistor models for c35b4
.include /opt/cad/designkits/ecs/hspice/c35b4.mod

** Include netlist file for nand3_ld
.include nand3_ld.spice

** Default 3.3V Power Supply
Vsupply Vdd GND 3.3V

** Specify input signals here
** e.g. for inputs A and B
**   VA A GND PWL(0NS 0V  2NS 0V  2.25NS 3.3V  6NS 3.3V  6.25NS 0V)
**   VB B GND PWL(0NS 0V  4NS 0V  4.25NS 3.3V  8NS 3.3V  8.25NS 0V)

VA A GND PWL(0NS 3.3V  2NS 3.3V  2.35NS 0V  6NS 0V  6.35NS 3.3V)
VB B GND PWL(0NS 3.3V  8NS 3.3V  8.35NS 0V  12NS 0V  12.35NS 3.3V)
VC C GND PWL(0NS 3.3V  14NS 3.3V  14.35NS 0V  20NS 0V  20.35NS 3.3V)

** Default Simulation - Type, Resolution & Duration
.TRAN 10PS 30NS

** Specify ouput signals to measure here
** e.g. rise and fall delays for output Y
**   .measure tran fall_delay TRIG v(Y) VAL='3.3*0.9' TD=0NS FALL=1
**   + TARG v(Y) VAL='3.3*0.1' TD=0NS FALL=1
**   .measure tran rise_delay TRIG v(Y) VAL='3.3*0.1' TD=0NS RISE=1
**   + TARG v(Y) VAL='3.3*0.9' TD=0NS RISE=1

.measure tran fall_delay_a
+TRIG v(Y) VAL='3.3*0.9' TD=0NS FALL=1
+TARG v(Y) VAL='3.3*0.1' TD=0NS FALL=1
.measure tran fall_delay_b
+TRIG v(Y) VAL='3.3*0.9' TD=0NS FALL=2
+TARG v(Y) VAL='3.3*0.1' TD=0NS FALL=2
.measure tran fall_delay_c
+TRIG v(Y) VAL='3.3*0.9' TD=0NS FALL=3
+TARG v(Y) VAL='3.3*0.1' TD=0NS FALL=3

.measure tran rise_delay_a
+TRIG v(Y) VAL='3.3*0.1' TD=0NS RISE=1
+TARG v(Y) VAL='3.3*0.9' TD=0NS RISE=1
.measure tran rise_delay_b
+TRIG v(Y) VAL='3.3*0.1' TD=0NS RISE=2
+TARG v(Y) VAL='3.3*0.9' TD=0NS RISE=2
.measure tran rise_delay_c
+TRIG v(Y) VAL='3.3*0.1' TD=0NS RISE=3
+TARG v(Y) VAL='3.3*0.9' TD=0NS RISE=3

.measure tran propagation_f
+TRIG v(C) VAL='3.3*0.5' TD=0NS RISE=1
+TARG v(Y) VAL='3.3*0.5' TD=0NS FALL=3
.measure tran propagation_r
+TRIG v(C) VAL='3.3*0.5' TD=0NS FALL=1
+TARG v(Y) VAL='3.3*0.5' TD=0NS RISE=3

** Save results for display
.OPTIONS POST
** Avoid DC convergence at unreasonable voltage
.OPTIONS GMINDC=1n

.END
